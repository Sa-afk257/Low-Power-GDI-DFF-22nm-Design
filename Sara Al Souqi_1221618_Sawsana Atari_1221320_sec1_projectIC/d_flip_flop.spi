*** SPICE deck for cell d_flip_flop{lay} from library IC_PROJ_1191375_1200902_1200078_1201369
*** Created on Mon Sep 04, 2023 16:43:26
*** Last revised on Tue Sep 05, 2023 16:03:12
*** Written on Mon Jun 16, 2025 17:23:56 by Electric VLSI Design System, version 9.08
*** Layout tech: mocmos, foundry MOSIS
*** UC SPICE *** , MIN_RESIST 4.0, MIN_CAPAC 0.1FF

*** TOP LEVEL CELL: IC_PROJ_1191375_1200902_1200078_1201369:d_flip_flop{lay}
Mnmos@0 net@0 net@218 net@1 gnd NMOS L=0.044U W=0.11U AS=0.022P AD=0.022P PS=0.594U PD=0.594U
Mnmos@3 net@22 net@27 gnd gnd NMOS L=0.044U W=0.11U AS=0.077P AD=0.022P PS=1.647U PD=0.594U
Mnmos@5 net@1 D gnd gnd NMOS L=0.044U W=0.11U AS=0.077P AD=0.022P PS=1.647U PD=0.594U
Mnmos@6 net@0 clk net@76 gnd NMOS L=0.044U W=0.11U AS=0.022P AD=0.022P PS=0.594U PD=0.594U
Mnmos@7 net@76 net@80 gnd gnd NMOS L=0.044U W=0.11U AS=0.077P AD=0.022P PS=1.647U PD=0.594U
Mnmos@8 net@27 clk net@80 gnd NMOS L=0.044U W=0.11U AS=0.022P AD=0.022P PS=0.594U PD=0.594U
Mnmos@9 net@80 net@0 gnd gnd NMOS L=0.044U W=0.11U AS=0.077P AD=0.022P PS=1.647U PD=0.594U
Mnmos@10 net@149 net@218 net@136 gnd NMOS L=0.044U W=0.11U AS=0.022P AD=0.022P PS=0.594U PD=0.594U
Mnmos@11 net@136 net@22 gnd gnd NMOS L=0.044U W=0.11U AS=0.077P AD=0.022P PS=1.647U PD=0.594U
Mnmos@12 Q net@22 gnd gnd NMOS L=0.044U W=0.11U AS=0.077P AD=0.022P PS=1.647U PD=0.594U
Mnmos@14 net@218 clk gnd gnd NMOS L=0.044U W=0.11U AS=0.077P AD=0.022P PS=1.647U PD=0.594U
Mpmos@0 net@0 clk net@1 vdd PMOS L=0.044U W=0.22U AS=0.022P AD=0.022P PS=0.594U PD=0.594U
Mpmos@3 net@22 net@27 vdd vdd PMOS L=0.044U W=0.22U AS=0.165P AD=0.022P PS=2.841U PD=0.594U
Mpmos@5 net@1 D vdd vdd PMOS L=0.044U W=0.22U AS=0.165P AD=0.022P PS=2.841U PD=0.594U
Mpmos@6 net@0 net@218 net@76 vdd PMOS L=0.044U W=0.22U AS=0.022P AD=0.022P PS=0.594U PD=0.594U
Mpmos@7 net@76 net@80 vdd vdd PMOS L=0.044U W=0.22U AS=0.165P AD=0.022P PS=2.841U PD=0.594U
Mpmos@8 net@27 net@218 net@80 vdd PMOS L=0.044U W=0.22U AS=0.022P AD=0.022P PS=0.594U PD=0.594U
Mpmos@9 net@80 net@0 vdd vdd PMOS L=0.044U W=0.22U AS=0.165P AD=0.022P PS=2.841U PD=0.594U
Mpmos@10 net@149 clk net@136 vdd PMOS L=0.044U W=0.22U AS=0.022P AD=0.022P PS=0.594U PD=0.594U
Mpmos@11 net@136 net@22 vdd vdd PMOS L=0.044U W=0.22U AS=0.165P AD=0.022P PS=2.841U PD=0.594U
Mpmos@12 Q net@22 vdd vdd PMOS L=0.044U W=0.22U AS=0.165P AD=0.022P PS=2.841U PD=0.594U
Mpmos@14 net@218 clk vdd vdd PMOS L=0.044U W=0.22U AS=0.165P AD=0.022P PS=2.841U PD=0.594U
.END
